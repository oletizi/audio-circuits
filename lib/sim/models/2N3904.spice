* 2N3904 - NPN small-signal bipolar transistor (TO-92)
*
* Provenance: this parameter set is the PSpice/OrCAD evaluation-library
* entry `Q2N3904`, and it is the version most widely redistributed across
* public SPICE model libraries (PSpice/LTspice/ngspice "standard"
* discrete-device libraries) and countless university course materials.
*
* Which company originated it is ambiguous in the public record and this
* file does not pick a winner it cannot support. Mirrors that preserve the
* comment block accompanying this exact parameter set read:
*
*     National   pid=23   case=TO92
*     88-09-08 bam   creation
*
* i.e. National Semiconductor, dated 88-09-08. A third mirror instead
* labels the same 26 values "Fairchild pid=23 case=TO92", but with the
* "88-09-08 bam creation" line stripped - a later relabelling of the same
* entry, not an independent second source. Corroborated 2026-09-22 via web
* search against multiple independent public mirrors; no single stable,
* directly-fetchable copy of a manufacturer-hosted original was located in
* this session. No parameter value here was invented; every value below
* was cross-checked against at least one independent public source before
* being recorded, and is identical across every mirror seen regardless of
* which company that mirror credits.
*
.model 2N3904 NPN(IS=6.734f XTI=3 EG=1.11 VAF=74.03 BF=416.4 NE=1.259 ISE=6.734f IKF=66.78m XTB=1.5 BR=.7371 NC=2 ISC=0 IKR=0 RC=1 CJC=3.638p MJC=.3085 VJC=.75 FC=.5 CJE=4.493p MJE=.2593 VJE=.75 TR=239.5n TF=301.2p ITF=.4 VTF=4 XTF=2 RB=10)
